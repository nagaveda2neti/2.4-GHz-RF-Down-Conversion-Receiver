ADE simulation setup
Test NAGA:cmos_cbp:1: NAGA/cmos_cbp/schematic, simulator spectre
  Models: /home/work/gpdk090_v4.6/libs.oa22/gpdk090/../../models/spectre/gpdk090.scs[NN]
  Variables: Vin = 1m; L_s = 110p; L = 20n
  Temperature: 27
  Files: definitions /home/work/Desktop/NAGA/nmpr.scs
  Analysis pss: engine=Shooting fund=100M harms=30
  Analysis pnoise: start=10k stop=100M dec=20 fund=100M p=/net023 iprobe=/PORT0 maxsideband=10 refsideband=-24 noisetype=timeaverage
  Signals: /net7, /net9, /net023
Run mode: Single Run, Sweeps and Corners
