ADE simulation setup
Run mode: Single Run, Sweeps and Corners
Tests:
  NAGA:cmos_cbp:1: NAGA/cmos_cbp/schematic, simulator spectre
    Variables: L = 20n; L_s = 110p; Vin = 1m
